ADE simulation setup
Test PSS_PNOISE: DAMSIC/demo_SCAmplifier_PNOISE_TB/schematic, simulator spectre
  Models: /esat/micas-data/data/design/generic/045/gpdk045_v_4_0/gpdk045/../models/spectre/gpdk045.scs[mc]
  Variables: alpha = 0.01; Cfb = 0.23p; Cin = 2.3025p; Cl = 2p; fin = 0; fsw = 60M; gm_OTA = 13m; C_OTA = 100f; ro_OTA = 1.5M; INCM = 55; OUTCMRef = 55; ron = 5; vdd = 1.1; Vin = 0
  Temperature: 27
  Analysis pnoise: start=10 stop=30M dec=15 fund=60M noisetype=sampled
  Analysis pss: engine=Shooting fund=60M harms=200
  Output v /phi<2>; pss (V) = vtime('pss "/phi<2>")
  Output Output Noise (V/sqrt(Hz)) = getData("out" ?result "pnoise_sample_pm0")
  Output Integrated Noise (V) = pow(integ(pow(clip(getData("out" ?result "pnoise_sample_pm0") 10 35000000) 2)) 0.5)
Run mode: Single Run, Sweeps and Corners
