ADE simulation setup
Test DAMSIC_SwitchedCapacitorAmplifier_TransientTestBench_1: DAMSIC/SCAmplifier_Transient_TB/schematic, simulator spectre
  Models: /esat/micas-data/data/design/generic/045/gpdk045_v_4_0/gpdk045/../models/spectre/gpdk045.scs[mc]
  Variables: RSW_OFF = 100M; RSW_ON = 1; VSW_TH = 0.55; C_OTA = 100f; gm_OTA = 13m; ro_OTA = 1.5M; INCM = 0.5; alpha = 0.01; Cfb = 0.23p; Cin = 2.3p; Cl = 2p; fin = 100K; fsw = 60M; OUTCMRef = 0.5; vdd = 1.1; Vin = 50m
  Temperature: 27
  Analysis tran: stop=2/VAR("fin") errpreset=conservative
  Analysis stb: start=1 stop=100G dec=20 probe=/I22 stbProbeMode=differential
  Output Loop Gain Phase = phaseDegUnwrapped(getData("loopGain" ?result "stb"))
  Output Loop Gain dB20 = db(mag(getData("loopGain" ?result "stb")))
  Signals: /VinP, /VinN, /phi<1>, /phi<2>, /INP, /INN, /OUTN, /OUTP, /VoutN, /VoutP, /OUTDM, /INDM, /OUTCM
Run mode: Single Run, Sweeps and Corners
