ADE simulation setup
Test DAMSIC_symmetric_OTA_gain_boosted_STB_TB_1: DAMSIC/symmetric_OTA_gain_boosted_STB_TB/schematic, simulator spectre
  Models: /esat/micas-data/data/design/generic/045/gpdk045_v_4_0/gpdk045/../models/spectre/gpdk045.scs[mc]
  Variables: Vmax = 100m; Vmin = 50m; alpha = 0.01; fin = 100k; fsw = 60M; Vin = 10m; Cfb = 0.23p; Cin = 2.3025p; Cl = 2p; gb1_dc = 1; gb2_dc = 0.2; gb_1_C = 135p; gb_1_gm = 20m; gb_1_ro = 20k; gb_2_C = 135p; gb_2_gm = 20m; gb_2_ro = 20k; INCM = 0.55; length = 90n; mult = 1; nf_Bias = 4000; nf_Inp = 600; nf_M2 = 300; nf_M3 = 900; nf_M4 = 100; nf_M5 = 500; nf_M6 = 100; p2_diffbias = 0.7; vdd = 1.1; VOCMRef = 550m
  Temperature: 27
  Analysis stb: start=1 stop=100G dec=20 probe=/I0/I5 stbProbeMode=differential
  Output Loop Phase = phaseDegUnwrapped(getData("loopGain" ?result "stb"))
  Output Loop Gain db20 = db(mag(getData("loopGain" ?result "stb")))
  Output ((VT("/OUTDM") + (VT("/INDM") * 10)) / (VT("/INDM") * 10))
  Output ymin(((VT("/OUTDM") + (VT("/INDM") * 10)) / (VT("/INDM") * 10)))
  Signals: /phi<1>, /phi<2>, /INDM, /OUTDM, /VinPP, /VinNN
Run mode: Single Run, Sweeps and Corners
Setup values for test DAMSIC_symmetric_OTA_gain_boosted_STB_TB_1: gb_1_ro = 15k; gb_2_ro = 15k
