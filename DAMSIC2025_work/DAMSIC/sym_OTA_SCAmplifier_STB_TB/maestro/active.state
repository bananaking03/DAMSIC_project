ADE simulation setup
Test STB: DAMSIC/demo_SCAmplifier_STB_TB/schematic, simulator spectre
  Models: /esat/micas-data/data/design/generic/045/gpdk045_v_4_0/gpdk045/../models/spectre/gpdk045.scs[mc]
  Variables: Vmax = 100m; Vmin = 50m; b1 = 700m; b5 = 1; b6 = 200m; length = 90n; mult = 1; nf_Bias = 4000; nf_Inp = 600; nf_M2 = 300; nf_M3 = 900; nf_M4 = 100; nf_M5 = 500; nf_M6 = 100; Cfb = 0.23p; Cin = 2.3025p; Cl = 2p; gm_OTA = 13m; ro_OTA = 1.5M; C_OTA = 100f; F_POLE2 = 1.5G; INCM = 0.55; OUTCMRef = 0.55; ron = 5; vdd = 1.1; fsw = 60k; alpha = 0.01; fin = 100k; Vin = 0; CP2 = 1/(6.28*F_POLE2)
  Temperature: 27
  Analysis dc
  Output Loop Gain Phase = phaseDegUnwrapped(getData("loopGain" ?result "stb")) (unticked)
  Output Loop Gain dB20 = db(mag(getData("loopGain" ?result "stb"))) (unticked)
  Output DIFF PAC OUT = (vh('pac "/VoutP") - vh('pac "/VoutN")) (unticked)
  Output CLK_PHI2 = vtime('pss "/phi<2>") (unticked)
  Output ((VT("/OUTDM") + (VT("/INDM") * 10)) / (VT("/INDM") * 10)) (unticked)
Run mode: Single Run, Sweeps and Corners
