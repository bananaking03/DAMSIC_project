ADE simulation setup
Run mode: Single Run, Sweeps and Corners
Tests:
  DAMSIC_symmetric_OTA_gain_boosted_STB_TB_1: DAMSIC/symmetric_OTA_gain_boosted_STB_TB/schematic, simulator spectre
    Variables: Cfb = 0.23p; Cin = 2.347p; Cl = 2p; gb1_dc = 1; gb2_dc = 0.2; gb_1_C = 135p; gb_1_gm = 20m; gb_1_ro = 15k; gb_2_C = 135p; gb_2_gm = 20m; gb_2_ro = 15k; INCM = 0.55; length = 90n; mult = 1; nf_Bias = 4000; nf_Inp = 600; nf_M2 = 300; nf_M3 = 900; nf_M4 = 100; nf_M5 = 500; nf_M6 = 100; p2_diffbias = 0.7; vdd = 1.1; VOCMRef = 550m; alpha = 0.01; fin = 100k; fsw = 60k; Vin = 10m; Vmax = 100m; Vmin = 50m; curr_b = 300m; ln0 = 1.8u; ln2 = 1u; ln3 = 1u; ln4 = 1u; lp0 = 1u; lp1 = 200n; nfn0 = 100; nfn2 = 1500; nfn3 = 100; nfn4 = 103; nfp0 = 100; nfp1 = 100; nm3_b = 786m; nm4_b = 506m; pm0_b = 400m; pm1_b = 645m; wfn0 = 2.5u; wfn2 = 10u; wfn3 = 1u; wfn4 = 1u; wfp0 = 1.82u; wfp1 = 5.29u
    Outputs: Loop Phase; Loop Gain db20; ((VT("/OUTDM") + (VT("/INDM") * 10)) / (VT("/INDM") * 10)); ymin(((VT("/OUTDM") + (VT("/INDM") * 10)) / (VT("/INDM") * 10))); /OUTCM; ((VT("/OUTDM") - (VT("/INDM") * 10)) / (VT("/INDM") * 10))
