ADE simulation setup
Run mode: Single Run, Sweeps and Corners
Tests:
  DAMSIC_gaiboosterideal_tb_1: DAMSIC/gaiboosterideal_tb/schematic, simulator spectre
    Variables: OUTCM = 1; vdd = 1.1; VINCM = 0.55
