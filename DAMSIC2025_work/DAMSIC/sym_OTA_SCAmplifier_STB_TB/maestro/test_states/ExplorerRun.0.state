ADE simulation setup
Test STB: DAMSIC/demo_SCAmplifier_STB_TB/schematic, simulator spectre
  Models: /esat/micas-data/data/design/generic/045/gpdk045_v_4_0/gpdk045/../models/spectre/gpdk045.scs[mc]
  Variables: C_OTA = 1p; Cfb = 0.2p; Cin = 2p; Cl = 2p; F_POLE2 = 1G; gm_OTA = 25m; INCM = 0.5; OUTCMRef = 0.5; ro_OTA = 2.5M; ron = 5; vdd = 1.1; CP2 = 1/(6.28*F_POLE2)
  Temperature: 27
  Analysis stb: start=1 stop=100G dec=20 probe=/I23 stbProbeMode=differential
  Output Loop Gain Phase = phaseDegUnwrapped(getData("loopGain" ?result "stb"))
  Output Loop Gain dB20 = db(mag(getData("loopGain" ?result "stb")))
