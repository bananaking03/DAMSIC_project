ADE simulation setup
Test DAMSIC_symmetric_OTA_gain_boosted_SpecTb_1: DAMSIC/symmetric_OTA_gain_boosted_SpecTb/schematic, simulator spectre
  Models: /esat/micas-data/data/design/generic/045/gpdk045_v_4_0/gpdk045/../models/spectre/gpdk045.scs[mc]
  Variables: gb1_dc = 1; gb2_dc = 0.2; gb_1_C = 135p; gb_1_gm = 20m; gb_1_ro = 20k; gb_2_C = 135p; gb_2_gm = 20m; gb_2_ro = 20k; length = 90n; mult = 1; nf_Bias = 4000; nf_Inp = 600; nf_M2 = 300; nf_M3 = 900; nf_M4 = 100; nf_M5 = 500; nf_M6 = 100; p2_diffbias = 0.7; vdd = 1.1; VINCM = 0.55; VOCMRef = 550m
  Temperature: 27
  Analysis dc: (saves the operating point)
  Analysis ac: start=1 stop=100G
  Output OP("/I0/PM2" "region")
  Output OP("/I0/PM1" "region")
  Output OP("/I0/NM1" "region")
  Output OP("/I0/PM5" "region")
  Output OP("/I0/PM6" "region")
  Output OP("/I0/NM4" "region")
  Output OP("/I0/NM3" "region")
  Output dB20(VF("/OUTDM"))
  Output phaseDeg(VF("/OUTDM"))
  Signals: /OUTDM
Run mode: Single Run, Sweeps and Corners
Setup values for test DAMSIC_symmetric_OTA_gain_boosted_SpecTb_1: gb_1_C = 10p; gb_2_C = 10p
