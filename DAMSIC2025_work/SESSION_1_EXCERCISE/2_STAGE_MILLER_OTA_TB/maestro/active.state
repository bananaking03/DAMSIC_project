ADE simulation setup
Test DAMSIC25_TB_2_STAGE_MILLER_OTA_TB_1: SESSION_1_EXCERCISE/2_STAGE_MILLER_OTA_TB/schematic, simulator spectre
  Models: /esat/micas-data/data/design/generic/045/gpdk045_v_4_0/gpdk045/../models/spectre/gpdk045.scs[mc]
  Variables: IBIAS = 10u; VCM = 0.5; VDD = 1
  Temperature: 27
  Analysis dc: (saves the operating point)
  Analysis stb: start=1 stop=1G dec=10 probe=/IPRB0 stbProbeMode=single-ended
  Output Loop Gain Phase = phaseDegUnwrapped(getData("loopGain" ?result "stb"))
  Output Loop Gain dB20 = db(mag(getData("loopGain" ?result "stb")))
Run mode: Single Run, Sweeps and Corners
