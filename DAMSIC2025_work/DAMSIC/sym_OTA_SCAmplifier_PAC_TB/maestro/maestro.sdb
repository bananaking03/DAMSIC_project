ADE simulation setup
Run mode: Single Run, Sweeps and Corners
Tests:
  DAMSIC_sym_OTA_SCAmplifier_PAC_TB_1: DAMSIC/sym_OTA_SCAmplifier_PAC_TB/schematic, simulator spectre
    Variables: alpha = 0.01; b1 = 0.7; b5 = 1; b6 = 0.2; Cfb = 0.23p; Cin = 2.3025p; Cl = 2p; fin = 0; fsw = 60M; INCM = 0.55; length = 90n; mult = 1; nf_Bias = 4000; nf_Inp = 600; nf_M2 = 300; nf_M3 = 900; nf_M4 = 100; nf_M5 = 500; nf_M6 = 100; OUTCMRef = 0.55; vdd = 1.1; Vin = 0; b7 = 0.477
    Outputs: CLK_PHI2; DIFF PAC OUTPUT; Output Noise (V/sqrt(Hz)); Integrated Noise
