ADE simulation setup
Run mode: Single Run, Sweeps and Corners
Tests:
  DAMSIC25_TB_2_STAGE_MILLER_OTA_TB_1: SESSION_1_EXCERCISE/2_STAGE_MILLER_OTA_IDEAL_TB_AC/schematic, simulator spectre
    Variables: IBIAS1 = 10u; IBIAS2 = 100u; gm1 = 10u; R1 = 0.6M; gm2 = 120u; R2 = 0.6M; C1 = 10f; CC = 3.33p; CL = 10p; VCM = 0.5; FB = 1; gm3 = 80u
