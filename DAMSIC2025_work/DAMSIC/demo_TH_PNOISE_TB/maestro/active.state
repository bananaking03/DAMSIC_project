ADE simulation setup
Test PSS_PNOISE: DAMSIC/demo_TH_PNOISE_TB/schematic, simulator spectre
  Models: /esat/micas-data/data/design/generic/045/gpdk045_v_4_0/gpdk045/../models/spectre/gpdk045.scs[mc]
  Variables: CSAMP = 1p; F_CLK = 10M; F_IN = 0; MULT_NMOS = 1; vdd = 1.1
  Temperature: 27
  Analysis pss: engine=Shooting fund=10M harms=200
  Analysis pnoise: start=1 stop=5M fund=10M noisetype=sampled
  Output Diff Output Noise (V/sqrt(Hz)) = getData("out" ?result "pnoise_sample_pm0")
  Output Diff Integrated Noise (V) = pow(integ(pow(clip(getData("out" ?result "pnoise_sample_pm0") 1 5000000) 2)) 0.5)
  Output Single Integrated Noise (V) = pow(integ(pow(clip(getData("out" ?result "pnoise_sample_pm1") 1 5000000) 2)) 0.5)
  Output v /CLK; pss (V) = vtime('pss "/CLK")
Run mode: Single Run, Sweeps and Corners
