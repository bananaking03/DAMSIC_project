ADE simulation setup
Test PSS_PNOISE: DAMSIC/demo_SCAmplifier_PAC_TB/schematic, simulator spectre
  Models: /esat/micas-data/data/design/generic/045/gpdk045_v_4_0/gpdk045/../models/spectre/gpdk045.scs[mc]
  Variables: alpha = 0.01; Cfb = 0.23p; Cin = 2.3025p; Cl = 2p; fin = 0; fsw = 60M; gm_OTA = 13m; C_OTA = 100f; ro_OTA = 1.5M; INCM = 0.5; OUTCMRef = 0.5; ron = 5; vdd = 1.1; Vin = 0
  Temperature: 27
  Analysis pss: engine=Shooting fund=VAR("fsw") harms=200
  Analysis pac: start=1 stop=50k dec=50 fund=VAR("fsw")
  Output CLK_PHI2 = vtime('pss "/phi<2>")
  Output DIFF PAC OUTPUT = (vh('pac "/VoutP") - vh('pac "/VoutN"))
Run mode: Single Run, Sweeps and Corners
