ADE simulation setup
Test DAMSIC25_TB_2_STAGE_MILLER_OTA_TB_1: SESSION_1_EXCERCISE/2_STAGE_MILLER_OTA_IDEAL_TB_AC/schematic, simulator spectre
  Models: /esat/micas-data/data/design/generic/045/gpdk045_v_4_0/gpdk045/../models/spectre/gpdk045.scs[mc]
  Variables: gm3 = 80u; FB = 1; IBIAS1 = 10u; IBIAS2 = 100u; gm1 = 10u; R1 = 0.6M; gm2 = 120u; R2 = 0.6M; C1 = 10f; CC = 3.33p; CL = 10p; VCM = 0.5
  Temperature: 27
  Analysis stb: start=1 stop=1G dec=10 probe=/IPRB1 stbProbeMode=single-ended
  Analysis dc: (saves the operating point)
  Output f = phaseDegUnwrapped(getData("loopGain" ?result "stb"))
  Output Loop Gain dB20 = db(mag(getData("loopGain" ?result "stb")))
  Output UGB = cross(db(mag(getData("loopGain" ?result "stb"))) "0" 1 "falling" nil nil nil)
  Output PM = value(phaseDegUnwrapped(getData("loopGain" ?result "stb")) cross(db(mag(getData("loopGain" ?result "stb"))) "0" 1 "falling" nil nil nil))
  Output DC GAIN = value(db(mag(getData("loopGain" ?result "stb"))) 0)
Run mode: Single Run, Sweeps and Corners
