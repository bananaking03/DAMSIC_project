ADE simulation setup
Test STB: DAMSIC/demo_SCAmplifier_STB_TB/schematic, simulator spectre
  Models: /esat/micas-data/data/design/generic/045/gpdk045_v_4_0/gpdk045/../models/spectre/gpdk045.scs[mc]
  Variables: alpha = 0.1; fin = 100k; Vin = 0; Cfb = 0.23p; Cin = 2.3025p; Cl = 2p; ro_OTA = 1.5M; C_OTA = 100f; F_POLE2 = 1.5G; INCM = 0.55; OUTCMRef = 0.55; ron = 5; vdd = 1.1; fsw = 60M; gm_OTA = 13m; CP2 = 1/(6.28*F_POLE2)
  Temperature: 27
  Analysis stb: start=1 stop=100G dec=20 probe=/I23 stbProbeMode=differential
  Output Loop Gain Phase = phaseDegUnwrapped(getData("loopGain" ?result "stb"))
  Output Loop Gain dB20 = db(mag(getData("loopGain" ?result "stb")))
  Output DIFF PAC OUT = (vh('pac "/VoutP") - vh('pac "/VoutN")) (unticked)
  Output CLK_PHI2 = vtime('pss "/phi<2>") (unticked)
Run mode: Single Run, Sweeps and Corners
