ADE simulation setup
Test DAMSIC_gain_booster_pmos_SpecTb_1: DAMSIC/gain_booster_pmos_SpecTb/schematic, simulator spectre
  Models: /esat/micas-data/data/design/generic/045/gpdk045_v_4_0/gpdk045/../models/spectre/gpdk045.scs[mc]
  Variables: INCM = 355m; INDM = 0; vdd = 1.1
  Temperature: 27
  Analysis dc: (saves the operating point)
  Analysis ac: start=10 stop=10G
  Output phaseDegUnwrapped(VF("/OUTDM"))
  Output dB20(VF("/OUTDM"))
  Signals: /OUTDM
Run mode: Single Run, Sweeps and Corners
