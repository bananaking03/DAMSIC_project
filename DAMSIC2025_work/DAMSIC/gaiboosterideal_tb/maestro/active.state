ADE simulation setup
Test DAMSIC_gaiboosterideal_tb_1: DAMSIC/gaiboosterideal_tb/schematic, simulator spectre
  Models: /esat/micas-data/data/design/generic/045/gpdk045_v_4_0/gpdk045/../models/spectre/gpdk045.scs[mc]
  Variables: OUTCM = 1; vdd = 1.1; VINCM = 0.55
  Temperature: 27
  Analysis ac: start=1 stop=100G
Run mode: Single Run, Sweeps and Corners
