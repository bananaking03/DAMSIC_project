ADE simulation setup
Test DAMSIC_gain_booster_nmos_SpecTb_1: DAMSIC/gain_booster_nmos_SpecTb/schematic, simulator spectre
  Models: /esat/micas-data/data/design/generic/045/gpdk045_v_4_0/gpdk045/../models/spectre/gpdk045.scs[mc]
  Variables: curr_b = 300m; INCM = 820m; INDM = 0; ln0 = 1.8u; ln2 = 1u; ln3 = 1u; ln4 = 1u; lp0 = 1u; lp1 = 200n; nfn0 = 100; nfn2 = 1500; nfn3 = 100; nfn4 = 103; nfp0 = 100; nfp1 = 100; nm3_b = 786m; nm4_b = 506m; pm0_b = 400m; pm1_b = 645m; vdd = 1.1; wfn0 = 2.5u; wfn2 = 10u; wfn3 = 1u; wfn4 = 1u; wfp0 = 1.82u; wfp1 = 5.29u
  Temperature: 27
  Analysis dc: (saves the operating point)
  Output OP("/I0/NM0" "region")
  Output OP("/I0/NM2" "region")
  Output OP("/I0/PM0" "region")
  Output OP("/I0/PM1" "region")
  Output OP("/I0/NM3" "region")
  Output OP("/I0/NM4" "region")
  Output dB20(VF("/OUTDM"))
  Output phaseDegUnwrapped(VF("/OUTDM"))
  Signals: /OUTDM
Run mode: Single Run, Sweeps and Corners
Setup values for test DAMSIC_gain_booster_nmos_SpecTb_1: pm1_b = 500m
