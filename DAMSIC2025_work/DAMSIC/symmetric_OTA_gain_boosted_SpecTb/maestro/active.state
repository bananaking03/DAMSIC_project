ADE simulation setup
Test DAMSIC_symmetric_OTA_gain_boosted_SpecTb_1: DAMSIC/symmetric_OTA_gain_boosted_SpecTb/schematic, simulator spectre
  Models: /esat/micas-data/data/design/generic/045/gpdk045_v_4_0/gpdk045/../models/spectre/gpdk045.scs[mc]
  Variables: capac = 0; curr_b = 300m; ln0 = 1.8u; ln2 = 1u; ln3 = 1u; ln4 = 1u; lp0 = 1u; lp1 = 200n; nfn0 = 100; nfn2 = 1500; nfn3 = 100; nfn4 = 103; nfp0 = 100; nfp1 = 100; nm3_b = 786m; nm4_b = 506m; pm0_b = 400m; pm1_b = 645m; wfn0 = 2.5u; wfn2 = 10u; wfn3 = 1u; wfn4 = 1u; wfp0 = 1.82u; wfp1 = 5.29u; gb1_dc = 1; gb2_dc = 0.2; gb_1_C = 10p; gb_1_gm = 20m; gb_1_ro = 15k; gb_2_C = 10p; gb_2_gm = 20m; gb_2_ro = 15k; length = 90n; mult = 1; nf_Bias = 4000; nf_Inp = 600; nf_M2 = 300; nf_M3 = 900; nf_M4 = 100; nf_M5 = 500; nf_M6 = 100; p2_diffbias = 0.7; vdd = 1.1; VINCM = 0.55; VOCMRef = 550m
  Temperature: 27
  Analysis dc: (saves the operating point)
  Output OP("/I0/PM2" "region") (unticked)
  Output OP("/I0/PM1" "region") (unticked)
  Output OP("/I0/NM1" "region") (unticked)
  Output OP("/I0/PM5" "region") (unticked)
  Output OP("/I0/PM6" "region") (unticked)
  Output OP("/I0/NM4" "region") (unticked)
  Output OP("/I0/NM3" "region") (unticked)
  Output dB20(VF("/OUTDM")) (unticked)
  Output phaseDegUnwrapped(VF("/OUTDM")) (unticked)
  Output Loop Gain dB20 = db(mag(getData("loopGain" ?result "stb"))) (unticked)
  Output Loop Gain Phase = phaseDegUnwrapped(getData("loopGain" ?result "stb")) (unticked)
  Signals: /OUTDM
Run mode: Single Run, Sweeps and Corners
Setup values for test DAMSIC_symmetric_OTA_gain_boosted_SpecTb_1: gb_1_ro = 20k; gb_2_ro = 20k
