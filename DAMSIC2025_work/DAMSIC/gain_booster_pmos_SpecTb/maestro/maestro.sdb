ADE simulation setup
Run mode: Single Run, Sweeps and Corners
Tests:
  DAMSIC_gain_booster_pmos_SpecTb_1: DAMSIC/gain_booster_pmos_SpecTb/schematic, simulator spectre
    Variables: INCM = 355m; INDM = 0; vdd = 1.1
