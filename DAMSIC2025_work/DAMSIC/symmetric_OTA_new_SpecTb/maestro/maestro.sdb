ADE simulation setup
Run mode: Single Run, Sweeps and Corners
Tests:
  DAMSIC_symmetric_OTA_new_SpecTb_1: DAMSIC/symmetric_OTA_new_SpecTb/schematic, simulator spectre
    Variables: INCM = 550m; INDM = 0; ln0 = 500n; ln2 = 2u; ln3 = 2.05u; lp0 = 1u; lp1 = 300n; lp3 = 2u; lp4 = 2u; nfn0 = 100; nfn2 = 100; nfn3 = 100; nfp0 = 240; nfp1 = 100; nfp3 = 100; nfp4 = 100; vn2 = 769m; vp0 = 743m; vp3 = 631m; vp4 = 379m; wfn0 = 1u; wfn2 = 1.95u; wfn3 = 2.62u; wfp0 = 9.15u; wfp1 = 1.58u; wfp3 = 2.88u; wfp4 = 3.527u
    Outputs: phaseDegUnwrapped(VF("/OUTDM"))
