ADE simulation setup
Test DAMSIC_SCAmplifier_trans_twopole_1: DAMSIC/SCAmplifier_trans_twopole/schematic, simulator spectre
  Models: /esat/micas-data/data/design/generic/045/gpdk045_v_4_0/gpdk045/../models/spectre/gpdk045.scs[mc]
  Variables: alpha = 0.01; C_OTA = 100f; Cfb = 0.23p; Cin = 2.3025p; Cl = 2p; gm_OTA = 13m; INCM = 0.55; OUTCMRef = 0.55; ro_OTA = 1.5M; RSW_OFF = 100G; RSW_ON = 10; vdd = 1.1; Vmax = 100m; Vmin = 50m; VSW_TH = 0.55; fsw = 60M; FPOLE2 = 1.5G; CP2 = 1/(6.28*FPOLE2)
  Temperature: 27
  Analysis tran: stop=6/VAR("fsw")
  Output gain error = ((VT("/OUTDM") + (VT("/INDM") * 10)) / (VT("/INDM") * 10))
  Output ymin(((VT("/OUTDM") + (VT("/INDM") * 10)) / (VT("/INDM") * 10))) (unticked)
  Signals: /VinP, /VinN, /INP, /INN, /OUTN, /OUTP, /VoutP, /VoutN, /OUTDM, /OUTCM, /INDM, /INNDM, /phi<1>, /INCM, /phi<2>, /net3, /net4
Run mode: Single Run, Sweeps and Corners
