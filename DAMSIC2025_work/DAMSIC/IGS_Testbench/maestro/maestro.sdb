ADE simulation setup
Run mode: Single Run, Sweeps and Corners
Tests:
  DAMSIC_2023_IGS_Testbench_1: DAMSIC/IGS_Testbench/schematic, simulator spectre
    Variables: VDD = 1; CL = 1p; Ln = 45n; IDn = 628u; NFn = 10; WFn = 1.15u; Lp = 45n; IDp = 500u; NFp = 10; WFp = 1u
    Outputs: |Av|,n; UGFn; Av0,n; VGSn; VDSn; gm,n; gm/ID,n; OP("/NM0" "gm"); gm,p; gm/ID,p; VDC("/Vinn"); VGSp; VDSp; |Av|,p; UGFp; Av0,p
Specs:
  DAMSIC_2023_IGS_Testbench_1 / Av0,n: > 0
  DAMSIC_2023_IGS_Testbench_1 / UGFn: > 1G
  DAMSIC_2023_IGS_Testbench_1 / VDSn: > (2 / calcVal("gm/ID,n"))
  DAMSIC_2023_IGS_Testbench_1 / VDSp: < (-1 * (2 / calcVal("gm/ID,p")))
  DAMSIC_2023_IGS_Testbench_1 / Av0,p: > 0
  DAMSIC_2023_IGS_Testbench_1 / UGFp: > 1G
  DAMSIC_2023_IGS_Testbench_1 / gm,n: > 6.28m
  DAMSIC_2023_IGS_Testbench_1 / gm,p: > 6.28m
