ADE simulation setup
Run mode: Single Run, Sweeps and Corners
Tests:
  DAMSIC_symmetric_OTA_gain_boosted_SpecTb_1: DAMSIC/symmetric_OTA_gain_boosted_SpecTb/schematic, simulator spectre
    Variables: gb1_dc = 1; gb2_dc = 0.2; gb_1_C = 135p; gb_1_gm = 20m; gb_1_ro = 20k; gb_2_C = 135p; gb_2_gm = 20m; gb_2_ro = 20k; length = 90n; mult = 1; nf_Bias = 4000; nf_Inp = 600; nf_M2 = 300; nf_M3 = 900; nf_M4 = 100; nf_M5 = 500; nf_M6 = 100; p2_diffbias = 0.7; vdd = 1.1; VINCM = 0.55; VOCMRef = 550m
