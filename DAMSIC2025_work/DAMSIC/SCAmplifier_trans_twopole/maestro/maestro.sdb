ADE simulation setup
Run mode: Single Run, Sweeps and Corners
Tests:
  DAMSIC_SCAmplifier_trans_twopole_1: DAMSIC/SCAmplifier_trans_twopole/schematic, simulator spectre
    Variables: fsw = 60M; alpha = 0.01; C_OTA = 100f; Cfb = 0.23p; Cin = 2.3025p; Cl = 2p; CP2 = 1/(6.28*FPOLE2); gm_OTA = 13m; INCM = 0.55; OUTCMRef = 0.55; ro_OTA = 1.5M; RSW_OFF = 100G; RSW_ON = 10; vdd = 1.1; Vmax = 100m; Vmin = 50m; VSW_TH = 0.55; FPOLE2 = 1.5G
    Outputs: gain error
