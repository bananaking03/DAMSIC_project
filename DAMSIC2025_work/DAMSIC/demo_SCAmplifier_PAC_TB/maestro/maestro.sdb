ADE simulation setup
Run mode: Single Run, Sweeps and Corners
Tests:
  PSS_PNOISE: DAMSIC/demo_SCAmplifier_PAC_TB/schematic, simulator spectre
    Variables: alpha = 0.01; Cfb = 0.23p; Cin = 2.3025p; Cl = 2p; fin = 0; fsw = 60M; gm_OTA = 13m; C_OTA = 100f; ro_OTA = 1.5M; INCM = 0.5; OUTCMRef = 0.5; ron = 5; vdd = 1.1; Vin = 0
