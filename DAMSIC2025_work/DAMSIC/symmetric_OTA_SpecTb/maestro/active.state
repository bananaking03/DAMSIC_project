ADE simulation setup
Test DAMSIC_symmetric_OTA_SpecTb_1: DAMSIC/symmetric_OTA_SpecTb/schematic, simulator spectre
  Models: /esat/micas-data/data/design/generic/045/gpdk045_v_4_0/gpdk045/../models/spectre/gpdk045.scs[mc]
  Variables: mult = 1; INCM = 0.55; b4 = 1; b5 = 0.20; length = 90n; diffBias = 0.7; nf_Bias = 4000; nf_Inp = 600; nf_M2 = 300; nf_M3 = 900; nf_M4 = 100; nf_M5 = 500; nf_M6 = 100; VOCMRef = 550m
  Temperature: 27
  Analysis dc: (saves the operating point)
  Analysis ac: start=1 stop=100G
  Output OP("/I0/PM2" "region") (unticked)
  Output OP("/I0/PM0" "region")
  Output OP("/I0/NM0" "region")
  Output OP("/I0/NM3" "region")
  Output OP("/I0/NM4" "region")
  Output OP("/I0/PM5" "region")
  Output OP("/I0/PM6" "region")
  Output db20(VF("/OUTDM"))
  Output phaseDeg(VF("/OUTDM"))
  Output VF("/OUTDM") (unticked)
  Output db20(VF("/OUTCM")) (unticked)
  Signals: /I0/PM2/S (terminal), /OUTDM, /OUTCM
Run mode: Single Run, Sweeps and Corners
Setup values for test DAMSIC_symmetric_OTA_SpecTb_1: b5 = 1; b6 = 0.2
