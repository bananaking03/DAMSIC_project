ADE simulation setup
Run mode: Single Run, Sweeps and Corners
Tests:
  DAMSIC25_TB_2_STAGE_MILLER_OTA_TB_1: SESSION_1_EXCERCISE/2_STAGE_MILLER_OTA_TB/schematic, simulator spectre
    Variables: IBIAS = 10u; VCM = 0.5; VDD = 1
