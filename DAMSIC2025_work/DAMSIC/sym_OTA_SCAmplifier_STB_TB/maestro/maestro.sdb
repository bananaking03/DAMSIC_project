ADE simulation setup
Run mode: Single Run, Sweeps and Corners
Tests:
  STB: DAMSIC/demo_SCAmplifier_STB_TB/schematic, simulator spectre
    Variables: Cfb = 0.23p; Cin = 2.3025p; Cl = 2p; gm_OTA = 13m; ro_OTA = 1.5M; C_OTA = 100f; F_POLE2 = 1.5G; CP2 = 1/(6.28*F_POLE2); INCM = 0.55; OUTCMRef = 0.55; ron = 5; vdd = 1.1; fsw = 60k; alpha = 0.01; fin = 100k; Vin = 0; b1 = 700m; b5 = 1; b6 = 200m; length = 90n; mult = 1; nf_Bias = 4000; nf_Inp = 600; nf_M2 = 300; nf_M3 = 900; nf_M4 = 100; nf_M5 = 500; nf_M6 = 100; Vmax = 100m; Vmin = 50m
    Outputs: DIFF PAC OUT; CLK_PHI2; /OUTDM; /OUTCM; /INDM; ((VT("/OUTDM") - (VT("/INDM") * 10)) / (VT("/INDM") * 10)); ((VT("/OUTDM") + (VT("/INDM") * 10)) / (VT("/INDM") * 10)); /VinP; /phi<1>; /phi<2>
