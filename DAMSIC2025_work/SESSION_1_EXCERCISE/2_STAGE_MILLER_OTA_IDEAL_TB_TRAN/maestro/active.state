ADE simulation setup
Test DAMSIC25_TB_2_STAGE_MILLER_OTA_TB_1: SESSION_1_EXCERCISE/2_STAGE_MILLER_OTA_IDEAL_TB_TRAN/schematic, simulator spectre
  Models: /esat/micas-data/data/design/generic/045/gpdk045_v_4_0/gpdk045/../models/spectre/gpdk045.scs[mc]
  Variables: FB = 1; IBIAS1 = 10u; IBIAS2 = 100u; gm1 = 60u; R1 = 0.5M; gm2 = 600u; R2 = 0.05M; C1 = 10f; CC = 3.33p; CL = 10p; VCM = 0.5
  Temperature: 27
  Analysis tran: stop=10u errpreset=conservative
  Output PERCENT_SETTLING_ERROR = (((value(VT("/VP") 1e-05) - value(VT("/VOUT") 1e-05)) / value(VT("/VP") 1e-05)) * 100)
  Output PERCENT_OVERSHOOT = (((ymax(VT("/VOUT")) - value(VT("/VP") 1e-05)) / value(VT("/VP") 1e-05)) * 100)
  Signals: /VP, /VOUT
Run mode: Single Run, Sweeps and Corners
