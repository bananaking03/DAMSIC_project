ADE simulation setup
Test DAMSIC_sym_OTA_SCAmplifier_PAC_TB_1: DAMSIC/sym_OTA_SCAmplifier_PAC_TB/schematic, simulator spectre
  Models: /esat/micas-data/data/design/generic/045/gpdk045_v_4_0/gpdk045/../models/spectre/gpdk045.scs[mc]
  Variables: b7 = 0.477; alpha = 0.01; b1 = 0.7; b5 = 1; b6 = 0.2; Cfb = 0.23p; Cin = 2.3025p; Cl = 2p; fin = 0; fsw = 60M; INCM = 0.55; length = 90n; mult = 1; nf_Bias = 4000; nf_Inp = 600; nf_M2 = 300; nf_M3 = 900; nf_M4 = 100; nf_M5 = 500; nf_M6 = 100; OUTCMRef = 0.55; vdd = 1.1; Vin = 0
  Temperature: 27
  Analysis pnoise: start=10 stop=30M dec=15 fund=VAR("fsw") noisetype=sampled
  Analysis pss: engine=Shooting fund=VAR("fsw") harms=200
  Output CLK_PHI2 = (vh('pac "/VoutP") - vh('pac "/VoutN"))
  Output DIFF PAC OUTPUT = vtime('pss "/phi<2>")
  Output VDC("/INP")
  Output VDC("/INN")
  Output Output Noise (V/sqrt(Hz)) = getData("out" ?result "pnoise_sample_pm0")
  Output Integrated Noise = pow(integ(pow(clip(getData("out" ?result "pnoise_sample_pm0") 10 35000000) 2)) 0.5)
  Signals: /INP, /INN, /OUTN, /OUTP
Run mode: Single Run, Sweeps and Corners
Setup values for test DAMSIC_sym_OTA_SCAmplifier_PAC_TB_1: b1 = 700m; b6 = 200m; fin = 100k; Vin = 10m
