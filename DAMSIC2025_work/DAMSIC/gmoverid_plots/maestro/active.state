ADE simulation setup
Test DAMSIC_2023_gmoverid_plots_1: DAMSIC/gmoverid_plots/schematic, simulator spectre
  Models: /esat/micas-data/data/design/generic/045/gpdk045_v_4_0/gpdk045/../models/spectre/gpdk045.scs[mc]
  Variables: Ln = 90n; NFn = 100; WFn = 605n; VGSn = 500m; VDSn = 250m; VSBn = 0; Lp = 90n; NFp = 500; WFp = 205n; VGSp = -500m; VDSp = -300m; VSBp = 0
  Temperature: 27
  Operating points saved: /NM0 (vth gds cgg gmoverid gm all); /PM0 (vth gds cgg gmoverid gm all)
  Analysis dc: sweep VGSp start=0 stop=-1.1 step=-10m (saves the operating point)
  Output Vth,n = OS("/NM0" "vth") (unticked)
  Output |Vth,p| = abs(OS("/PM0" "vth")) (unticked)
  Output IDn = IS("/NM0/D") (unticked)
  Output |IDp| = abs(IS("/PM0/D")) (unticked)
  Output gm,n = OS("/NM0" "gm") (unticked)
  Output gm,p = OS("/PM0" "gm")
  Output 1/gds,n = (1 / OS("/NM0" "gds")) (unticked)
  Output 1/gds,p = (1 / OS("/PM0" "gds")) (unticked)
  Output gm/ID,n = OS("/NM0" "gmoverid") (unticked)
  Output gm/ID,p = OS("/PM0" "gmoverid") (unticked)
  Output fT,n = (OS("/NM0" "gm") / (2 * pi * OS("/NM0" "cgg"))) (unticked)
  Output fT,p = (OS("/PM0" "gm") / (2 * pi * OS("/PM0" "cgg"))) (unticked)
  Output (Aintr,n)dB = dB20((OS("/NM0" "gm") / OS("/NM0" "gds"))) (unticked)
  Output (Aintr,p)dB = dB20((OS("/PM0" "gm") / OS("/PM0" "gds"))) (unticked)
  Output fT,n*Aintr,n = ((OS("/NM0" "gm") / (2 * pi * OS("/NM0" "cgg"))) * (OS("/NM0" "gm") / OS("/NM0" "gds"))) (unticked)
  Output fT,p*Aintr,p = ((OS("/PM0" "gm") / (2 * pi * OS("/PM0" "cgg"))) * (OS("/PM0" "gm") / OS("/PM0" "gds"))) (unticked)
  Output gm,n vs gm/ID,n = waveVsWave(?x OS("/NM0" "gmoverid") ?y OS("/NM0" "gm")) (unticked)
  Output gm,p vs gm/ID,p = waveVsWave(?x OS("/PM0" "gmoverid") ?y OS("/PM0" "gm")) (unticked)
  Output fT,n vs gm/ID,n = waveVsWave(?x OS("/NM0" "gmoverid") ?y (OS("/NM0" "gm") / (2 * pi * OS("/NM0" "cgg")))) (unticked)
  Output fT,p vs gm/ID,p = waveVsWave(?x OS("/PM0" "gmoverid") ?y (OS("/PM0" "gm") / (2 * pi * OS("/PM0" "cgg")))) (unticked)
  Output Aintr,n vs gm/ID,n = waveVsWave(?x OS("/NM0" "gmoverid") ?y dB20((OS("/NM0" "gm") / OS("/NM0" "gds")))) (unticked)
  Output Aintr,p vs gm/ID,p = waveVsWave(?x OS("/PM0" "gmoverid") ?y dB20((OS("/PM0" "gm") / OS("/PM0" "gds")))) (unticked)
  Output fT,n*Aintr,n vs gm/ID,n = waveVsWave(?x OS("/NM0" "gmoverid") ?y ((OS("/NM0" "gm") / (2 * pi * OS("/NM0" "cgg"))) * (OS("/NM0" "gm") / OS("/NM0" "gds")))) (unticked)
  Output fT,p*Aintr,p vs gm/ID,p = waveVsWave(?x OS("/PM0" "gmoverid") ?y ((OS("/PM0" "gm") / (2 * pi * OS("/PM0" "cgg"))) * (OS("/PM0" "gm") / OS("/PM0" "gds")))) (unticked)
  Output ID,n/W vs gm/ID,n = waveVsWave(?x OS("/NM0" "gmoverid") ?y (IS("/NM0/D") / (VAR("NFn") * VAR("WFn")))) (unticked)
  Output |ID,p|/W vs gm/ID,p = waveVsWave(?x OS("/PM0" "gmoverid") ?y (abs(IS("/PM0/D")) / (VAR("NFp") * VAR("WFp"))))
  Output 1/gds,n vs gm/ID,n = waveVsWave(?x OS("/NM0" "gmoverid") ?y (1 / OS("/NM0" "gds"))) (unticked)
  Output 1/gds,p vs gm/ID,p = waveVsWave(?x OS("/PM0" "gmoverid") ?y (1 / OS("/PM0" "gds"))) (unticked)
  Signals: /NM0/D (terminal), /PM0/D (terminal)
Run mode: Single Run, Sweeps and Corners
Global variables:
  Ln = 45n
Setup values for test DAMSIC_2023_gmoverid_plots_1: VSBn = 250m; Ln = 500n; WFn = 1u; VDSn = 500m; Lp = 300n; NFp = 100; WFp = 1.58u; VGSp = -450m; VDSp = -500m; VSBp = -100m
