ADE simulation setup
Test DAMSIC_2023_IGS_Testbench_1: DAMSIC/IGS_Testbench/schematic, simulator spectre
  Models: /esat/micas-data/data/design/generic/045/gpdk045_v_4_0/gpdk045/../models/spectre/gpdk045.scs[mc]
  Variables: VDD = 1; CL = 1p; Ln = 45n; IDn = 628u; NFn = 10; WFn = 1.15u; Lp = 45n; IDp = 500u; NFp = 10; WFp = 1u
  Temperature: 27
  Operating points saved: /NM0 (all); /PM0 (all)
  Analysis dc: (saves the operating point)
  Analysis ac: start=1 stop=100G dec=101
  Output gm,n = OP("/NM0" "gm") (unticked)
  Output gm,p = OP("/PM0" "gm")
  Output gm/ID,n = OP("/NM0" "gmoverid") (unticked)
  Output gm/ID,p = OP("/PM0" "gmoverid")
  Output VGSn = VDC("/Vinn") (unticked)
  Output VDSn = VDC("/Voutn") (unticked)
  Output |Av|,n = dB20(mag(VF("/Voutn"))) (unticked)
  Output UGFn = cross(dB20(mag(VF("/Voutn"))) 0) (unticked)
  Output Av0,n = value(dB20(mag(VF("/Voutn"))) 1) (unticked)
  Output VGSp = (VDC("/Vinp") - VDC("/vdd!"))
  Output VDSp = (VDC("/Voutp") - VDC("/vdd!"))
  Output |Av|,p = dB20(mag(VF("/Voutp")))
  Output UGFp = cross(dB20(mag(VF("/Voutp"))) 0)
  Output Av0,p = value(dB20(mag(VF("/Voutp"))) 1)
Run mode: Single Run, Sweeps and Corners
Specs:
  DAMSIC_2023_IGS_Testbench_1 / Av0,n: > 0
  DAMSIC_2023_IGS_Testbench_1 / UGFn: > 1G
  DAMSIC_2023_IGS_Testbench_1 / VDSn: > (2 / calcVal("gm/ID,n"))
  DAMSIC_2023_IGS_Testbench_1 / VDSp: < (-1 * (2 / calcVal("gm/ID,p")))
  DAMSIC_2023_IGS_Testbench_1 / Av0,p: > 0
  DAMSIC_2023_IGS_Testbench_1 / UGFp: > 1G
  DAMSIC_2023_IGS_Testbench_1 / gm,n: > 6.28m
  DAMSIC_2023_IGS_Testbench_1 / gm,p: > 6.28m
