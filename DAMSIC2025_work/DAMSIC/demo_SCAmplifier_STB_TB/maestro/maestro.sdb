ADE simulation setup
Run mode: Single Run, Sweeps and Corners
Tests:
  STB: DAMSIC/demo_SCAmplifier_STB_TB/schematic, simulator spectre
    Variables: Cfb = 0.23p; Cin = 2.3025p; Cl = 2p; gm_OTA = 13m; ro_OTA = 1.5M; C_OTA = 100f; F_POLE2 = 1.5G; CP2 = 1/(6.28*F_POLE2); INCM = 0.55; OUTCMRef = 0.55; ron = 5; vdd = 1.1; fsw = 60M; alpha = 0.1; fin = 100k; Vin = 0
    Outputs: DIFF PAC OUT; CLK_PHI2
