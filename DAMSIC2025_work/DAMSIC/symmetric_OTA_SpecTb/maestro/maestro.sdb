ADE simulation setup
Run mode: Single Run, Sweeps and Corners
Tests:
  DAMSIC_symmetric_OTA_SpecTb_1: DAMSIC/symmetric_OTA_SpecTb/schematic, simulator spectre
    Variables: nf_Bias = 4000; nf_Inp = 600; nf_M2 = 300; nf_M3 = 900; nf_M4 = 100; nf_M5 = 500; nf_M6 = 100; diffBias = 0.7; length = 90n; b4 = 1; b5 = 0.20; INCM = 0.55; mult = 1; VOCMRef = 550m
    Outputs: OP("/I0/NM3" "region"); OP("/I0/NM4" "region"); OP("/I0/PM5" "region"); OP("/I0/PM6" "region"); mag(VF("/OUTDM")); db20(VF("/OUTDM")); db20(VF("/OUTCM"))
