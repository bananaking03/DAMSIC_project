ADE simulation setup
Run mode: Single Run, Sweeps and Corners
Tests:
  DAMSIC_gain_booster_nmos_SpecTb_1: DAMSIC/gain_booster_nmos_SpecTb/schematic, simulator spectre
    Variables: curr_b = 300m; INCM = 820m; INDM = 0; ln0 = 1.8u; ln2 = 1u; ln3 = 1u; ln4 = 1u; lp0 = 1u; lp1 = 200n; nfn0 = 100; nfn2 = 1500; nfn3 = 100; nfn4 = 103; nfp0 = 100; nfp1 = 100; nm3_b = 786m; nm4_b = 506m; pm0_b = 400m; pm1_b = 645m; vdd = 1.1; wfn0 = 2.5u; wfn2 = 10u; wfn3 = 1u; wfn4 = 1u; wfp0 = 1.82u; wfp1 = 5.29u
