ADE simulation setup
Test DAMSIC_symmetric_OTA_gain_boosted_PAC_TB_1: DAMSIC/symmetric_OTA_gain_boosted_PAC_TB/schematic, simulator spectre
  Models: /esat/micas-data/data/design/generic/045/gpdk045_v_4_0/gpdk045/../models/spectre/gpdk045.scs[mc]
  Variables: curr_b = 300m; nm3_b = 786m; nm4_b = 506m; pm0_b = 400m; pm1_b = 645m; ln0 = 1.8u; ln2 = 1u; ln3 = 1u; ln4 = 1u; lp0 = 1u; lp1 = 200n; nfn0 = 100; nfn2 = 1500; nfn3 = 100; nfn4 = 103; nfp0 = 100; nfp1 = 100; wfn0 = 2.5u; wfn2 = 10u; wfn3 = 1u; wfn4 = 1u; wfp0 = 1.82u; wfp1 = 5.29u; alpha = 0.01; Cfb = 0.23p; Cin = 2.347p; Cl = 2p; fin = 0; fsw = 100k; gb1_dc = 1; gb2_dc = 0.2; gb_1_C = 135p; gb_1_gm = 15m; gb_1_ro = 15k; gb_2_C = 135p; gb_2_gm = 15m; gb_2_ro = 15k; INCM = 550m; length = 90n; mult = 1; nf_Bias = 4000; nf_Inp = 600; nf_M2 = 300; nf_M3 = 900; nf_M4 = 100; nf_M5 = 500; nf_M6 = 100; p2_diffbias = 0.7; vdd = 1.1; Vin = 0; VOCMRef = 550m
  Temperature: 27
  Analysis pac: start=1 stop=50k dec=50 fund=VAR("fsw")
  Analysis pnoise: start=10 stop=30M dec=15 fund=VAR("fsw") noisetype=sampled
  Analysis pss: engine=Shooting fund=VAR("fsw") harms=100
  Output CLK_PHI2 = (vh('pac "/VoutP") - vh('pac "/VoutN"))
  Output DIFF PAC OUT = vtime('pss "/phi<2>")
  Output Output Noise (V/sqrt(Hz)) = getData("out" ?result "pnoise_sample_pm0")
  Output Integrated Noise (V) = pow(integ(pow(clip(getData("out" ?result "pnoise_sample_pm0") 10 35000000) 2)) 0.5)
  Signals: /phi<1>
Run mode: Single Run, Sweeps and Corners
Setup values for test DAMSIC_symmetric_OTA_gain_boosted_PAC_TB_1: Cin = 2.34p; gb_1_gm = 20m; gb_1_ro = 20k; gb_2_gm = 20m; gb_2_ro = 20k
